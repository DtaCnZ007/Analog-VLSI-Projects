** sch_path: /home/instaneous/my_circuit_project/inv_testbench.sch
**.subckt inv_testbench
V1 VDD GND 3
V2 VIN GND PULSE (0 1.2 0 1n 1n 1u 2u)
x1 VDD VIN VOUT GND inv
**** begin user architecture code

.lib /home/instaneous/.volare/volare/sky130/versions/0fe599b2afb6708d281543108caf8310912f54af/sky130A/libs.tech/ngspice/sky130.lib.spice tt

.control
tran 1u 10u
.endc

**** end user architecture code
**.ends

* expanding   symbol:  my_circuit_project/inv.sym # of pins=4
** sym_path: /home/instaneous/my_circuit_project/inv.sym
** sch_path: /home/instaneous/my_circuit_project/inv.sch
.subckt inv VDD VIN VOUT GND
*.ipin VDD
*.ipin VIN
*.ipin GND
*.opin VOUT
XM1 VOUT VIN GND GND sky130_fd_pr__nfet_01v8 L=0.15 W=1 nf=1 ad='int((nf+1)/2) * W/nf * 0.29' as='int((nf+2)/2) * W/nf * 0.29' pd='2*int((nf+1)/2) * (W/nf + 0.29)'
+ ps='2*int((nf+2)/2) * (W/nf + 0.29)' nrd='0.29 / W' nrs='0.29 / W' sa=0 sb=0 sd=0 mult=1
XM2 VOUT VIN VDD VDD sky130_fd_pr__pfet_01v8 L=0.15 W=1 nf=1 ad='int((nf+1)/2) * W/nf * 0.29' as='int((nf+2)/2) * W/nf * 0.29' pd='2*int((nf+1)/2) * (W/nf + 0.29)'
+ ps='2*int((nf+2)/2) * (W/nf + 0.29)' nrd='0.29 / W' nrs='0.29 / W' sa=0 sb=0 sd=0 mult=1
.ends

.GLOBAL GND
.end
