** sch_path: /home/instaneous/diff_pair.sch
**.subckt diff_pair VDD VOUT1 VOUT2 VIN1 VIN2 VB
*.ipin VIN1
*.ipin VIN2
*.ipin VB
*.ipin VDD
*.iopin VOUT1
*.iopin VOUT2
XM1 VOUT1 VIN1 net1 0 sky130_fd_pr__nfet_01v8 L=0.15 W=1 nf=1 ad='int((nf+1)/2) * W/nf * 0.29' as='int((nf+2)/2) * W/nf * 0.29' pd='2*int((nf+1)/2) * (W/nf + 0.29)'
+ ps='2*int((nf+2)/2) * (W/nf + 0.29)' nrd='0.29 / W' nrs='0.29 / W' sa=0 sb=0 sd=0 mult=1
XM2 net1 VB 0 0 sky130_fd_pr__nfet_01v8 L=0.15 W=1 nf=1 ad='int((nf+1)/2) * W/nf * 0.29' as='int((nf+2)/2) * W/nf * 0.29' pd='2*int((nf+1)/2) * (W/nf + 0.29)'
+ ps='2*int((nf+2)/2) * (W/nf + 0.29)' nrd='0.29 / W' nrs='0.29 / W' sa=0 sb=0 sd=0 mult=1
XM3 VOUT2 VIN2 net1 0 sky130_fd_pr__nfet_01v8 L=0.15 W=1 nf=1 ad='int((nf+1)/2) * W/nf * 0.29' as='int((nf+2)/2) * W/nf * 0.29' pd='2*int((nf+1)/2) * (W/nf + 0.29)'
+ ps='2*int((nf+2)/2) * (W/nf + 0.29)' nrd='0.29 / W' nrs='0.29 / W' sa=0 sb=0 sd=0 mult=1
XRD VOUT1 VDD 0 sky130_fd_pr__res_high_po W=1 L=1 mult=1
XRD1 VOUT2 VDD 0 sky130_fd_pr__res_high_po W=1 L=1 mult=1
**.ends
.end
