** sch_path: /home/instaneous/diff_pair_mismatch.sch
**.subckt diff_pair_mismatch VDD VOUT2 VOUT1 VIN1 VIN2 VT VB
*.ipin VDD
*.ipin VB
*.iopin VOUT2
*.iopin VOUT1
*.iopin VT
*.ipin VIN2
*.ipin VIN1
XM1 VOUT1 VIN1 VT GND sky130_fd_pr__nfet_01v8 L=0.15 W=1 nf=1 ad='int((nf+1)/2) * W/nf * 0.29' as='int((nf+2)/2) * W/nf * 0.29' pd='2*int((nf+1)/2) * (W/nf + 0.29)'
+ ps='2*int((nf+2)/2) * (W/nf + 0.29)' nrd='0.29 / W' nrs='0.29 / W' sa=0 sb=0 sd=0 mult=1
XM2 VOUT2 VIN2 VT GND sky130_fd_pr__nfet_01v8 L=0.15 W=1.02 nf=1 ad='int((nf+1)/2) * W/nf * 0.29' as='int((nf+2)/2) * W/nf * 0.29'
+ pd='2*int((nf+1)/2) * (W/nf + 0.29)' ps='2*int((nf+2)/2) * (W/nf + 0.29)' nrd='0.29 / W' nrs='0.29 / W' sa=0 sb=0 sd=0 mult=1
XM3 VT VB 0 GND sky130_fd_pr__nfet_01v8 L=0.15 W=1 nf=1 ad='int((nf+1)/2) * W/nf * 0.29' as='int((nf+2)/2) * W/nf * 0.29' pd='2*int((nf+1)/2) * (W/nf + 0.29)'
+ ps='2*int((nf+2)/2) * (W/nf + 0.29)' nrd='0.29 / W' nrs='0.29 / W' sa=0 sb=0 sd=0 mult=1
XR1 VOUT1 VDD net1 sky130_fd_pr__res_high_po W=1 L=1000 mult=1
XR2 VOUT2 VDD net2 sky130_fd_pr__res_high_po W=1 L=1010 mult=1
**.ends
.end
