** sch_path: /home/instaneous/diff_pair_mismatchanaylsis.sch
**.subckt diff_pair_mismatchanaylsis
x1 net1 VOUT1 VOUT2 net2 net3 VT net4 diff_pair_mismatch
V1 net1 0 1.8
V2 net4 0 0.8
V4 net3 0 DC 1.1 AC 0.5 180
V3 net2 0 DC 1.1 AC 0.5 0
**** begin user architecture code

.lib /home/instaneous/.volare/volare/sky130/versions/0fe599b2afb6708d281543108caf8310912f54af/sky130B/libs.tech/combined/sky130.lib.spice tt
.ac dec 10 1k 10G
.control
run
plot mag(v(vout1) - v(vout2))
.endc

**** end user architecture code
**.ends

* expanding   symbol:  diff_pair_mismatch.sym # of pins=7
** sym_path: /home/instaneous/diff_pair_mismatch.sym
** sch_path: /home/instaneous/diff_pair_mismatch.sch
.subckt diff_pair_mismatch VDD VOUT2 VOUT1 VIN1 VIN2 VT VB
*.ipin VDD
*.ipin VB
*.iopin VOUT2
*.iopin VOUT1
*.iopin VT
*.ipin VIN2
*.ipin VIN1
XM1 VOUT1 VIN1 VT GND sky130_fd_pr__nfet_01v8 L=0.15 W=1 nf=1 ad='int((nf+1)/2) * W/nf * 0.29' as='int((nf+2)/2) * W/nf * 0.29' pd='2*int((nf+1)/2) * (W/nf + 0.29)'
+ ps='2*int((nf+2)/2) * (W/nf + 0.29)' nrd='0.29 / W' nrs='0.29 / W' sa=0 sb=0 sd=0 mult=1
XM2 VOUT2 VIN2 VT GND sky130_fd_pr__nfet_01v8 L=0.15 W=1.02 nf=1 ad='int((nf+1)/2) * W/nf * 0.29' as='int((nf+2)/2) * W/nf * 0.29'
+ pd='2*int((nf+1)/2) * (W/nf + 0.29)' ps='2*int((nf+2)/2) * (W/nf + 0.29)' nrd='0.29 / W' nrs='0.29 / W' sa=0 sb=0 sd=0 mult=1
XM3 VT VB 0 GND sky130_fd_pr__nfet_01v8 L=0.15 W=1 nf=1 ad='int((nf+1)/2) * W/nf * 0.29' as='int((nf+2)/2) * W/nf * 0.29' pd='2*int((nf+1)/2) * (W/nf + 0.29)'
+ ps='2*int((nf+2)/2) * (W/nf + 0.29)' nrd='0.29 / W' nrs='0.29 / W' sa=0 sb=0 sd=0 mult=1
XR1 VOUT1 VDD net1 sky130_fd_pr__res_high_po W=1 L=1000 mult=1
XR2 VOUT2 VDD net2 sky130_fd_pr__res_high_po W=1 L=1010 mult=1
.ends

.end
